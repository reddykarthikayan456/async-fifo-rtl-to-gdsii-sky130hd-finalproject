* CDL Netlist generated by OpenROAD

*.BUSDELIMITER [

.SUBCKT async_fifo din[0] din[1] din[2] din[3] din[4] din[5]
+ din[6] din[7] dout[0] dout[1] dout[2] dout[3] dout[4] dout[5]
+ dout[6] dout[7] empty full rd_clk rd_en rst_n wr_clk wr_en
+ VDD VSS
X_44_ wbin\[2\] _00_ VSS VSS VDD VDD _37_ sky130_fd_sc_hd__xnor2_1
X_45_ _37_ VSS VSS VDD VDD wbin_next\[2\] sky130_fd_sc_hd__inv_1
X_46_ rbin\[2\] _01_ VSS VSS VDD VDD rbin_next\[2\] sky130_fd_sc_hd__xor2_1
X_47_ rbin_next\[1\] rbin_next\[2\] VSS VSS VDD VDD rgray_next\[1\]
+ sky130_fd_sc_hd__xor2_1
X_48_ rbin_next\[1\] rbin_next\[0\] VSS VSS VDD VDD rgray_next\[0\]
+ sky130_fd_sc_hd__xor2_1
X_49_ wbin_next\[1\] _37_ VSS VSS VDD VDD wgray_next\[1\]
+ sky130_fd_sc_hd__xnor2_1
X_50_ wbin_next\[1\] wbin_next\[0\] VSS VSS VDD VDD wgray_next\[0\]
+ sky130_fd_sc_hd__xor2_1
X_51_ net21 net11 VSS VSS VDD VDD winc sky130_fd_sc_hd__nor2b_1
X_52_ net20 net9 VSS VSS VDD VDD _38_ sky130_fd_sc_hd__nor2b_1
Xinput3 din[2] VSS VSS VDD VDD net3 sky130_fd_sc_hd__clkdlybuf4s50_1
Xinput2 din[1] VSS VSS VDD VDD net2 sky130_fd_sc_hd__clkdlybuf4s50_1
Xinput1 din[0] VSS VSS VDD VDD net1 sky130_fd_sc_hd__clkdlybuf4s50_1
X_56_ mem\[0\]\[6\] mem\[1\]\[6\] mem\[2\]\[6\] mem\[3\]\[6\]
+ rbin\[0\] rbin\[1\] VSS VSS VDD VDD _41_ sky130_fd_sc_hd__mux4_1
X_57_ net18 _41_ _38_ VSS VSS VDD VDD _06_ sky130_fd_sc_hd__mux2_2
X_58_ mem\[0\]\[5\] mem\[1\]\[5\] mem\[2\]\[5\] mem\[3\]\[5\]
+ rbin\[0\] rbin\[1\] VSS VSS VDD VDD _14_ sky130_fd_sc_hd__mux4_1
X_59_ net17 _14_ _38_ VSS VSS VDD VDD _07_ sky130_fd_sc_hd__mux2_2
X_60_ mem\[0\]\[4\] mem\[1\]\[4\] mem\[2\]\[4\] mem\[3\]\[4\]
+ rbin\[0\] rbin\[1\] VSS VSS VDD VDD _15_ sky130_fd_sc_hd__mux4_1
X_61_ net16 _15_ _38_ VSS VSS VDD VDD _08_ sky130_fd_sc_hd__mux2_2
X_62_ mem\[0\]\[3\] mem\[1\]\[3\] mem\[2\]\[3\] mem\[3\]\[3\]
+ rbin\[0\] rbin\[1\] VSS VSS VDD VDD _16_ sky130_fd_sc_hd__mux4_1
X_63_ net15 _16_ _38_ VSS VSS VDD VDD _09_ sky130_fd_sc_hd__mux2_2
X_64_ mem\[0\]\[2\] mem\[1\]\[2\] mem\[2\]\[2\] mem\[3\]\[2\]
+ rbin\[0\] rbin\[1\] VSS VSS VDD VDD _17_ sky130_fd_sc_hd__mux4_1
X_65_ net14 _17_ _38_ VSS VSS VDD VDD _10_ sky130_fd_sc_hd__mux2_2
X_66_ mem\[0\]\[1\] mem\[1\]\[1\] mem\[2\]\[1\] mem\[3\]\[1\]
+ rbin\[0\] rbin\[1\] VSS VSS VDD VDD _18_ sky130_fd_sc_hd__mux4_1
X_67_ net13 _18_ _38_ VSS VSS VDD VDD _11_ sky130_fd_sc_hd__mux2_2
X_68_ mem\[0\]\[0\] mem\[1\]\[0\] mem\[2\]\[0\] mem\[3\]\[0\]
+ rbin\[0\] rbin\[1\] VSS VSS VDD VDD _19_ sky130_fd_sc_hd__mux4_1
X_69_ net12 _19_ _38_ VSS VSS VDD VDD _12_ sky130_fd_sc_hd__mux2_2
X_70_ mem\[0\]\[7\] mem\[2\]\[7\] mem\[1\]\[7\] mem\[3\]\[7\]
+ rbin\[1\] rbin\[0\] VSS VSS VDD VDD _20_ sky130_fd_sc_hd__mux4_2
X_71_ net19 _20_ _38_ VSS VSS VDD VDD _13_ sky130_fd_sc_hd__mux2_2
X_72_ net23 winc VSS VSS VDD VDD _21_ sky130_fd_sc_hd__nand2_1
X_73_ wbin\[1\] wbin\[0\] _21_ VSS VSS VDD VDD _02_ sky130_fd_sc_hd__nor3_2
X_74_ wbin\[1\] net23 wbin\[0\] winc VSS VSS VDD VDD _03_
+ sky130_fd_sc_hd__and4_1
X_75_ _21_ wbin\[1\] wbin\[0\] VSS VSS VDD VDD _04_ sky130_fd_sc_hd__nor3b_2
X_76_ wbin\[0\] _21_ wbin\[1\] VSS VSS VDD VDD _05_ sky130_fd_sc_hd__nor3b_2
X_77_ rgray_w2\[2\] rgray_w2\[1\] VSS VSS VDD VDD _22_ sky130_fd_sc_hd__nand2b_1
X_78_ rgray_w2\[2\] _37_ VSS VSS VDD VDD _23_ sky130_fd_sc_hd__nand2_1
X_79_ _37_ _22_ _23_ rgray_w2\[1\] VSS VSS VDD VDD _24_ sky130_fd_sc_hd__o22ai_1
X_80_ rgray_w2\[0\] wbin_next\[0\] VSS VSS VDD VDD _25_ sky130_fd_sc_hd__xor2_1
X_81_ rgray_w2\[1\] rgray_w2\[2\] _37_ VSS VSS VDD VDD _26_
+ sky130_fd_sc_hd__nand3_1
X_82_ rgray_w2\[1\] rgray_w2\[2\] _37_ VSS VSS VDD VDD _27_
+ sky130_fd_sc_hd__or3_1
X_83_ _26_ _27_ wbin_next\[1\] _25_ VSS VSS VDD VDD _28_ sky130_fd_sc_hd__a211oi_1
X_84_ wbin_next\[1\] _24_ _25_ _28_ VSS VSS VDD VDD full_next
+ sky130_fd_sc_hd__a31o_2
X_85_ wgray_r2\[0\] rbin_next\[0\] VSS VSS VDD VDD _29_ sky130_fd_sc_hd__xor2_1
X_86_ rbin_next\[1\] _29_ VSS VSS VDD VDD _30_ sky130_fd_sc_hd__and2_1
X_87_ wgray_r2\[2\] rbin_next\[2\] VSS VSS VDD VDD _31_ sky130_fd_sc_hd__nor2_1
X_88_ _30_ _31_ VSS VSS VDD VDD _32_ sky130_fd_sc_hd__nand2_1
X_89_ rbin_next\[1\] _29_ VSS VSS VDD VDD _33_ sky130_fd_sc_hd__nor2_1
X_90_ wgray_r2\[2\] rbin_next\[2\] VSS VSS VDD VDD _34_ sky130_fd_sc_hd__and2_1
X_91_ _33_ _34_ VSS VSS VDD VDD _35_ sky130_fd_sc_hd__nand2_1
X_92_ _31_ _33_ _34_ _30_ wgray_r2\[1\] VSS VSS VDD VDD _36_
+ sky130_fd_sc_hd__a221oi_1
X_93_ wgray_r2\[1\] _32_ _35_ _36_ VSS VSS VDD VDD empty_next
+ sky130_fd_sc_hd__a31oi_1
X_94_ wbin\[1\] _42_ VSS VSS VDD VDD _00_ wbin_next\[1\] sky130_fd_sc_hd__ha_1
X_95_ rbin\[0\] _38_ VSS VSS VDD VDD _43_ rbin_next\[0\] sky130_fd_sc_hd__ha_1
X_96_ wbin\[0\] winc VSS VSS VDD VDD _42_ wbin_next\[0\] sky130_fd_sc_hd__ha_1
X_97_ rbin\[1\] _43_ VSS VSS VDD VDD _01_ rbin_next\[1\] sky130_fd_sc_hd__ha_1
Xdout\[0\]$_DFFE_PN0P_ clknet_1_1__leaf_rd_clk _12_ net23
+ VSS VSS VDD VDD net12 sky130_fd_sc_hd__dfrtp_1
Xdout\[1\]$_DFFE_PN0P_ clknet_1_1__leaf_rd_clk _11_ net23
+ VSS VSS VDD VDD net13 sky130_fd_sc_hd__dfrtp_1
Xdout\[2\]$_DFFE_PN0P_ clknet_1_1__leaf_rd_clk _10_ net23
+ VSS VSS VDD VDD net14 sky130_fd_sc_hd__dfrtp_1
Xdout\[3\]$_DFFE_PN0P_ clknet_1_1__leaf_rd_clk _09_ net23
+ VSS VSS VDD VDD net15 sky130_fd_sc_hd__dfrtp_1
Xdout\[4\]$_DFFE_PN0P_ clknet_1_1__leaf_rd_clk _08_ net23
+ VSS VSS VDD VDD net16 sky130_fd_sc_hd__dfrtp_1
Xdout\[5\]$_DFFE_PN0P_ clknet_1_0__leaf_rd_clk _07_ net23
+ VSS VSS VDD VDD net17 sky130_fd_sc_hd__dfrtp_1
Xdout\[6\]$_DFFE_PN0P_ clknet_1_1__leaf_rd_clk _06_ net23
+ VSS VSS VDD VDD net18 sky130_fd_sc_hd__dfrtp_1
Xdout\[7\]$_DFFE_PN0P_ clknet_1_1__leaf_rd_clk _13_ net23
+ VSS VSS VDD VDD net19 sky130_fd_sc_hd__dfrtp_1
Xempty$_DFF_PN1_ clknet_1_0__leaf_rd_clk empty_next net23
+ VSS VSS VDD VDD net20 sky130_fd_sc_hd__dfstp_2
Xfull$_DFF_PN0_ clknet_2_0__leaf_wr_clk full_next net23 VSS
+ VSS VDD VDD net21 sky130_fd_sc_hd__dfrtp_1
Xmem\[0\]\[0\]$_DFFE_PP_ clknet_2_2__leaf_wr_clk net1 _02_
+ VSS VSS VDD VDD mem\[0\]\[0\] sky130_fd_sc_hd__edfxtp_1
Xmem\[0\]\[1\]$_DFFE_PP_ clknet_2_3__leaf_wr_clk net2 _02_
+ VSS VSS VDD VDD mem\[0\]\[1\] sky130_fd_sc_hd__edfxtp_1
Xmem\[0\]\[2\]$_DFFE_PP_ clknet_2_3__leaf_wr_clk net3 _02_
+ VSS VSS VDD VDD mem\[0\]\[2\] sky130_fd_sc_hd__edfxtp_1
Xmem\[0\]\[3\]$_DFFE_PP_ clknet_2_2__leaf_wr_clk net4 _02_
+ VSS VSS VDD VDD mem\[0\]\[3\] sky130_fd_sc_hd__edfxtp_1
Xmem\[0\]\[4\]$_DFFE_PP_ clknet_2_2__leaf_wr_clk net5 _02_
+ VSS VSS VDD VDD mem\[0\]\[4\] sky130_fd_sc_hd__edfxtp_1
Xmem\[0\]\[5\]$_DFFE_PP_ clknet_2_2__leaf_wr_clk net6 _02_
+ VSS VSS VDD VDD mem\[0\]\[5\] sky130_fd_sc_hd__edfxtp_1
Xmem\[0\]\[6\]$_DFFE_PP_ clknet_2_1__leaf_wr_clk net7 _02_
+ VSS VSS VDD VDD mem\[0\]\[6\] sky130_fd_sc_hd__edfxtp_1
Xmem\[0\]\[7\]$_DFFE_PP_ clknet_2_1__leaf_wr_clk net8 _02_
+ VSS VSS VDD VDD mem\[0\]\[7\] sky130_fd_sc_hd__edfxtp_1
Xmem\[1\]\[0\]$_DFFE_PP_ clknet_2_2__leaf_wr_clk net1 _04_
+ VSS VSS VDD VDD mem\[1\]\[0\] sky130_fd_sc_hd__edfxtp_1
Xmem\[1\]\[1\]$_DFFE_PP_ clknet_2_3__leaf_wr_clk net2 _04_
+ VSS VSS VDD VDD mem\[1\]\[1\] sky130_fd_sc_hd__edfxtp_1
Xmem\[1\]\[2\]$_DFFE_PP_ clknet_2_3__leaf_wr_clk net3 _04_
+ VSS VSS VDD VDD mem\[1\]\[2\] sky130_fd_sc_hd__edfxtp_1
Xmem\[1\]\[3\]$_DFFE_PP_ clknet_2_2__leaf_wr_clk net4 _04_
+ VSS VSS VDD VDD mem\[1\]\[3\] sky130_fd_sc_hd__edfxtp_1
Xmem\[1\]\[4\]$_DFFE_PP_ clknet_2_2__leaf_wr_clk net5 _04_
+ VSS VSS VDD VDD mem\[1\]\[4\] sky130_fd_sc_hd__edfxtp_1
Xmem\[1\]\[5\]$_DFFE_PP_ clknet_2_2__leaf_wr_clk net6 _04_
+ VSS VSS VDD VDD mem\[1\]\[5\] sky130_fd_sc_hd__edfxtp_1
Xmem\[1\]\[6\]$_DFFE_PP_ clknet_2_3__leaf_wr_clk net7 _04_
+ VSS VSS VDD VDD mem\[1\]\[6\] sky130_fd_sc_hd__edfxtp_1
Xmem\[1\]\[7\]$_DFFE_PP_ clknet_2_0__leaf_wr_clk net8 _04_
+ VSS VSS VDD VDD mem\[1\]\[7\] sky130_fd_sc_hd__edfxtp_1
Xmem\[2\]\[0\]$_DFFE_PP_ clknet_2_3__leaf_wr_clk net1 _05_
+ VSS VSS VDD VDD mem\[2\]\[0\] sky130_fd_sc_hd__edfxtp_1
Xmem\[2\]\[1\]$_DFFE_PP_ clknet_2_3__leaf_wr_clk net2 _05_
+ VSS VSS VDD VDD mem\[2\]\[1\] sky130_fd_sc_hd__edfxtp_1
Xmem\[2\]\[2\]$_DFFE_PP_ clknet_2_3__leaf_wr_clk net3 _05_
+ VSS VSS VDD VDD mem\[2\]\[2\] sky130_fd_sc_hd__edfxtp_1
Xmem\[2\]\[3\]$_DFFE_PP_ clknet_2_2__leaf_wr_clk net4 _05_
+ VSS VSS VDD VDD mem\[2\]\[3\] sky130_fd_sc_hd__edfxtp_1
Xmem\[2\]\[4\]$_DFFE_PP_ clknet_2_2__leaf_wr_clk net5 _05_
+ VSS VSS VDD VDD mem\[2\]\[4\] sky130_fd_sc_hd__edfxtp_1
Xmem\[2\]\[5\]$_DFFE_PP_ clknet_2_2__leaf_wr_clk net6 _05_
+ VSS VSS VDD VDD mem\[2\]\[5\] sky130_fd_sc_hd__edfxtp_1
Xmem\[2\]\[6\]$_DFFE_PP_ clknet_2_3__leaf_wr_clk net7 _05_
+ VSS VSS VDD VDD mem\[2\]\[6\] sky130_fd_sc_hd__edfxtp_1
Xmem\[2\]\[7\]$_DFFE_PP_ clknet_2_1__leaf_wr_clk net8 _05_
+ VSS VSS VDD VDD mem\[2\]\[7\] sky130_fd_sc_hd__edfxtp_1
Xmem\[3\]\[0\]$_DFFE_PP_ clknet_2_2__leaf_wr_clk net1 _03_
+ VSS VSS VDD VDD mem\[3\]\[0\] sky130_fd_sc_hd__edfxtp_1
Xmem\[3\]\[1\]$_DFFE_PP_ clknet_2_3__leaf_wr_clk net2 _03_
+ VSS VSS VDD VDD mem\[3\]\[1\] sky130_fd_sc_hd__edfxtp_1
Xmem\[3\]\[2\]$_DFFE_PP_ clknet_2_3__leaf_wr_clk net3 _03_
+ VSS VSS VDD VDD mem\[3\]\[2\] sky130_fd_sc_hd__edfxtp_1
Xmem\[3\]\[3\]$_DFFE_PP_ clknet_2_2__leaf_wr_clk net4 _03_
+ VSS VSS VDD VDD mem\[3\]\[3\] sky130_fd_sc_hd__edfxtp_1
Xmem\[3\]\[4\]$_DFFE_PP_ clknet_2_2__leaf_wr_clk net5 _03_
+ VSS VSS VDD VDD mem\[3\]\[4\] sky130_fd_sc_hd__edfxtp_1
Xmem\[3\]\[5\]$_DFFE_PP_ clknet_2_0__leaf_wr_clk net6 _03_
+ VSS VSS VDD VDD mem\[3\]\[5\] sky130_fd_sc_hd__edfxtp_1
Xmem\[3\]\[6\]$_DFFE_PP_ clknet_2_3__leaf_wr_clk net7 _03_
+ VSS VSS VDD VDD mem\[3\]\[6\] sky130_fd_sc_hd__edfxtp_1
Xmem\[3\]\[7\]$_DFFE_PP_ clknet_2_1__leaf_wr_clk net8 _03_
+ VSS VSS VDD VDD mem\[3\]\[7\] sky130_fd_sc_hd__edfxtp_1
Xrbin\[0\]$_DFF_PN0_ clknet_1_1__leaf_rd_clk rbin_next\[0\]
+ net23 VSS VSS VDD VDD rbin\[0\] sky130_fd_sc_hd__dfrtp_1
Xrbin\[1\]$_DFF_PN0_ clknet_1_0__leaf_rd_clk rbin_next\[1\]
+ net23 VSS VSS VDD VDD rbin\[1\] sky130_fd_sc_hd__dfrtp_1
Xrbin\[2\]$_DFF_PN0_ clknet_1_0__leaf_rd_clk rbin_next\[2\]
+ net23 VSS VSS VDD VDD rbin\[2\] sky130_fd_sc_hd__dfrtp_1
Xrgray\[0\]$_DFF_PN0_ clknet_1_0__leaf_rd_clk rgray_next\[0\]
+ net23 VSS VSS VDD VDD rgray\[0\] sky130_fd_sc_hd__dfrtp_1
Xrgray\[1\]$_DFF_PN0_ clknet_1_0__leaf_rd_clk rgray_next\[1\]
+ net23 VSS VSS VDD VDD rgray\[1\] sky130_fd_sc_hd__dfrtp_1
Xrgray_w1\[0\]$_DFF_PN0_ clknet_2_1__leaf_wr_clk rgray\[0\]
+ net23 VSS VSS VDD VDD rgray_w1\[0\] sky130_fd_sc_hd__dfrtp_1
Xrgray_w1\[1\]$_DFF_PN0_ clknet_2_1__leaf_wr_clk rgray\[1\]
+ net23 VSS VSS VDD VDD rgray_w1\[1\] sky130_fd_sc_hd__dfrtp_1
Xrgray_w1\[2\]$_DFF_PN0_ clknet_2_1__leaf_wr_clk rbin\[2\]
+ net23 VSS VSS VDD VDD rgray_w1\[2\] sky130_fd_sc_hd__dfrtp_1
Xrgray_w2\[0\]$_DFF_PN0_ clknet_2_1__leaf_wr_clk rgray_w1\[0\]
+ net23 VSS VSS VDD VDD rgray_w2\[0\] sky130_fd_sc_hd__dfrtp_1
Xrgray_w2\[1\]$_DFF_PN0_ clknet_2_1__leaf_wr_clk rgray_w1\[1\]
+ net23 VSS VSS VDD VDD rgray_w2\[1\] sky130_fd_sc_hd__dfrtp_1
Xrgray_w2\[2\]$_DFF_PN0_ clknet_2_1__leaf_wr_clk rgray_w1\[2\]
+ net23 VSS VSS VDD VDD rgray_w2\[2\] sky130_fd_sc_hd__dfrtp_1
Xwbin\[0\]$_DFF_PN0_ clknet_2_0__leaf_wr_clk wbin_next\[0\]
+ net23 VSS VSS VDD VDD wbin\[0\] sky130_fd_sc_hd__dfrtp_1
Xwbin\[1\]$_DFF_PN0_ clknet_2_0__leaf_wr_clk wbin_next\[1\]
+ net23 VSS VSS VDD VDD wbin\[1\] sky130_fd_sc_hd__dfrtp_1
Xwbin\[2\]$_DFF_PN0_ clknet_2_0__leaf_wr_clk wbin_next\[2\]
+ net23 VSS VSS VDD VDD wbin\[2\] sky130_fd_sc_hd__dfrtp_1
Xwgray\[0\]$_DFF_PN0_ clknet_2_0__leaf_wr_clk wgray_next\[0\]
+ net23 VSS VSS VDD VDD wgray\[0\] sky130_fd_sc_hd__dfrtp_1
Xwgray\[1\]$_DFF_PN0_ clknet_2_0__leaf_wr_clk wgray_next\[1\]
+ net23 VSS VSS VDD VDD wgray\[1\] sky130_fd_sc_hd__dfrtp_1
Xwgray_r1\[0\]$_DFF_PN0_ clknet_1_0__leaf_rd_clk wgray\[0\]
+ net23 VSS VSS VDD VDD wgray_r1\[0\] sky130_fd_sc_hd__dfrtp_1
Xwgray_r1\[1\]$_DFF_PN0_ clknet_1_0__leaf_rd_clk wgray\[1\]
+ net23 VSS VSS VDD VDD wgray_r1\[1\] sky130_fd_sc_hd__dfrtp_1
Xwgray_r1\[2\]$_DFF_PN0_ clknet_1_0__leaf_rd_clk wbin\[2\]
+ net23 VSS VSS VDD VDD wgray_r1\[2\] sky130_fd_sc_hd__dfrtp_1
Xwgray_r2\[0\]$_DFF_PN0_ clknet_1_0__leaf_rd_clk wgray_r1\[0\]
+ net23 VSS VSS VDD VDD wgray_r2\[0\] sky130_fd_sc_hd__dfrtp_1
Xwgray_r2\[1\]$_DFF_PN0_ clknet_1_0__leaf_rd_clk wgray_r1\[1\]
+ net23 VSS VSS VDD VDD wgray_r2\[1\] sky130_fd_sc_hd__dfrtp_1
Xwgray_r2\[2\]$_DFF_PN0_ clknet_1_0__leaf_rd_clk wgray_r1\[2\]
+ net23 VSS VSS VDD VDD wgray_r2\[2\] sky130_fd_sc_hd__dfrtp_1
XTAP_TAPCELL_ROW_0_0 VSS VDD sky130_fd_sc_hd__tapvpwrvgnd_1
XTAP_TAPCELL_ROW_0_1 VSS VDD sky130_fd_sc_hd__tapvpwrvgnd_1
XTAP_TAPCELL_ROW_0_2 VSS VDD sky130_fd_sc_hd__tapvpwrvgnd_1
XTAP_TAPCELL_ROW_0_3 VSS VDD sky130_fd_sc_hd__tapvpwrvgnd_1
XTAP_TAPCELL_ROW_0_4 VSS VDD sky130_fd_sc_hd__tapvpwrvgnd_1
XTAP_TAPCELL_ROW_1_5 VSS VDD sky130_fd_sc_hd__tapvpwrvgnd_1
XTAP_TAPCELL_ROW_1_6 VSS VDD sky130_fd_sc_hd__tapvpwrvgnd_1
XTAP_TAPCELL_ROW_2_7 VSS VDD sky130_fd_sc_hd__tapvpwrvgnd_1
XTAP_TAPCELL_ROW_2_8 VSS VDD sky130_fd_sc_hd__tapvpwrvgnd_1
XTAP_TAPCELL_ROW_2_9 VSS VDD sky130_fd_sc_hd__tapvpwrvgnd_1
XTAP_TAPCELL_ROW_3_10 VSS VDD sky130_fd_sc_hd__tapvpwrvgnd_1
XTAP_TAPCELL_ROW_3_11 VSS VDD sky130_fd_sc_hd__tapvpwrvgnd_1
XTAP_TAPCELL_ROW_4_12 VSS VDD sky130_fd_sc_hd__tapvpwrvgnd_1
XTAP_TAPCELL_ROW_4_13 VSS VDD sky130_fd_sc_hd__tapvpwrvgnd_1
XTAP_TAPCELL_ROW_4_14 VSS VDD sky130_fd_sc_hd__tapvpwrvgnd_1
XTAP_TAPCELL_ROW_5_15 VSS VDD sky130_fd_sc_hd__tapvpwrvgnd_1
XTAP_TAPCELL_ROW_5_16 VSS VDD sky130_fd_sc_hd__tapvpwrvgnd_1
XTAP_TAPCELL_ROW_6_17 VSS VDD sky130_fd_sc_hd__tapvpwrvgnd_1
XTAP_TAPCELL_ROW_6_18 VSS VDD sky130_fd_sc_hd__tapvpwrvgnd_1
XTAP_TAPCELL_ROW_6_19 VSS VDD sky130_fd_sc_hd__tapvpwrvgnd_1
XTAP_TAPCELL_ROW_7_20 VSS VDD sky130_fd_sc_hd__tapvpwrvgnd_1
XTAP_TAPCELL_ROW_7_21 VSS VDD sky130_fd_sc_hd__tapvpwrvgnd_1
XTAP_TAPCELL_ROW_8_22 VSS VDD sky130_fd_sc_hd__tapvpwrvgnd_1
XTAP_TAPCELL_ROW_8_23 VSS VDD sky130_fd_sc_hd__tapvpwrvgnd_1
XTAP_TAPCELL_ROW_8_24 VSS VDD sky130_fd_sc_hd__tapvpwrvgnd_1
XTAP_TAPCELL_ROW_9_25 VSS VDD sky130_fd_sc_hd__tapvpwrvgnd_1
XTAP_TAPCELL_ROW_9_26 VSS VDD sky130_fd_sc_hd__tapvpwrvgnd_1
XTAP_TAPCELL_ROW_10_27 VSS VDD sky130_fd_sc_hd__tapvpwrvgnd_1
XTAP_TAPCELL_ROW_10_28 VSS VDD sky130_fd_sc_hd__tapvpwrvgnd_1
XTAP_TAPCELL_ROW_10_29 VSS VDD sky130_fd_sc_hd__tapvpwrvgnd_1
XTAP_TAPCELL_ROW_11_30 VSS VDD sky130_fd_sc_hd__tapvpwrvgnd_1
XTAP_TAPCELL_ROW_11_31 VSS VDD sky130_fd_sc_hd__tapvpwrvgnd_1
XTAP_TAPCELL_ROW_12_32 VSS VDD sky130_fd_sc_hd__tapvpwrvgnd_1
XTAP_TAPCELL_ROW_12_33 VSS VDD sky130_fd_sc_hd__tapvpwrvgnd_1
XTAP_TAPCELL_ROW_12_34 VSS VDD sky130_fd_sc_hd__tapvpwrvgnd_1
XTAP_TAPCELL_ROW_13_35 VSS VDD sky130_fd_sc_hd__tapvpwrvgnd_1
XTAP_TAPCELL_ROW_13_36 VSS VDD sky130_fd_sc_hd__tapvpwrvgnd_1
XTAP_TAPCELL_ROW_14_37 VSS VDD sky130_fd_sc_hd__tapvpwrvgnd_1
XTAP_TAPCELL_ROW_14_38 VSS VDD sky130_fd_sc_hd__tapvpwrvgnd_1
XTAP_TAPCELL_ROW_14_39 VSS VDD sky130_fd_sc_hd__tapvpwrvgnd_1
XTAP_TAPCELL_ROW_15_40 VSS VDD sky130_fd_sc_hd__tapvpwrvgnd_1
XTAP_TAPCELL_ROW_15_41 VSS VDD sky130_fd_sc_hd__tapvpwrvgnd_1
XTAP_TAPCELL_ROW_16_42 VSS VDD sky130_fd_sc_hd__tapvpwrvgnd_1
XTAP_TAPCELL_ROW_16_43 VSS VDD sky130_fd_sc_hd__tapvpwrvgnd_1
XTAP_TAPCELL_ROW_16_44 VSS VDD sky130_fd_sc_hd__tapvpwrvgnd_1
XTAP_TAPCELL_ROW_17_45 VSS VDD sky130_fd_sc_hd__tapvpwrvgnd_1
XTAP_TAPCELL_ROW_17_46 VSS VDD sky130_fd_sc_hd__tapvpwrvgnd_1
XTAP_TAPCELL_ROW_18_47 VSS VDD sky130_fd_sc_hd__tapvpwrvgnd_1
XTAP_TAPCELL_ROW_18_48 VSS VDD sky130_fd_sc_hd__tapvpwrvgnd_1
XTAP_TAPCELL_ROW_18_49 VSS VDD sky130_fd_sc_hd__tapvpwrvgnd_1
XTAP_TAPCELL_ROW_19_50 VSS VDD sky130_fd_sc_hd__tapvpwrvgnd_1
XTAP_TAPCELL_ROW_19_51 VSS VDD sky130_fd_sc_hd__tapvpwrvgnd_1
XTAP_TAPCELL_ROW_20_52 VSS VDD sky130_fd_sc_hd__tapvpwrvgnd_1
XTAP_TAPCELL_ROW_20_53 VSS VDD sky130_fd_sc_hd__tapvpwrvgnd_1
XTAP_TAPCELL_ROW_20_54 VSS VDD sky130_fd_sc_hd__tapvpwrvgnd_1
XTAP_TAPCELL_ROW_21_55 VSS VDD sky130_fd_sc_hd__tapvpwrvgnd_1
XTAP_TAPCELL_ROW_21_56 VSS VDD sky130_fd_sc_hd__tapvpwrvgnd_1
XTAP_TAPCELL_ROW_22_57 VSS VDD sky130_fd_sc_hd__tapvpwrvgnd_1
XTAP_TAPCELL_ROW_22_58 VSS VDD sky130_fd_sc_hd__tapvpwrvgnd_1
XTAP_TAPCELL_ROW_22_59 VSS VDD sky130_fd_sc_hd__tapvpwrvgnd_1
XTAP_TAPCELL_ROW_23_60 VSS VDD sky130_fd_sc_hd__tapvpwrvgnd_1
XTAP_TAPCELL_ROW_23_61 VSS VDD sky130_fd_sc_hd__tapvpwrvgnd_1
XTAP_TAPCELL_ROW_24_62 VSS VDD sky130_fd_sc_hd__tapvpwrvgnd_1
XTAP_TAPCELL_ROW_24_63 VSS VDD sky130_fd_sc_hd__tapvpwrvgnd_1
XTAP_TAPCELL_ROW_24_64 VSS VDD sky130_fd_sc_hd__tapvpwrvgnd_1
XTAP_TAPCELL_ROW_25_65 VSS VDD sky130_fd_sc_hd__tapvpwrvgnd_1
XTAP_TAPCELL_ROW_25_66 VSS VDD sky130_fd_sc_hd__tapvpwrvgnd_1
XTAP_TAPCELL_ROW_26_67 VSS VDD sky130_fd_sc_hd__tapvpwrvgnd_1
XTAP_TAPCELL_ROW_26_68 VSS VDD sky130_fd_sc_hd__tapvpwrvgnd_1
XTAP_TAPCELL_ROW_26_69 VSS VDD sky130_fd_sc_hd__tapvpwrvgnd_1
XTAP_TAPCELL_ROW_27_70 VSS VDD sky130_fd_sc_hd__tapvpwrvgnd_1
XTAP_TAPCELL_ROW_27_71 VSS VDD sky130_fd_sc_hd__tapvpwrvgnd_1
XTAP_TAPCELL_ROW_28_72 VSS VDD sky130_fd_sc_hd__tapvpwrvgnd_1
XTAP_TAPCELL_ROW_28_73 VSS VDD sky130_fd_sc_hd__tapvpwrvgnd_1
XTAP_TAPCELL_ROW_28_74 VSS VDD sky130_fd_sc_hd__tapvpwrvgnd_1
XTAP_TAPCELL_ROW_28_75 VSS VDD sky130_fd_sc_hd__tapvpwrvgnd_1
XTAP_TAPCELL_ROW_28_76 VSS VDD sky130_fd_sc_hd__tapvpwrvgnd_1
Xinput4 din[3] VSS VSS VDD VDD net4 sky130_fd_sc_hd__clkdlybuf4s50_1
Xinput5 din[4] VSS VSS VDD VDD net5 sky130_fd_sc_hd__clkdlybuf4s50_1
Xinput6 din[5] VSS VSS VDD VDD net6 sky130_fd_sc_hd__clkdlybuf4s50_1
Xinput7 din[6] VSS VSS VDD VDD net7 sky130_fd_sc_hd__clkdlybuf4s50_1
Xinput8 din[7] VSS VSS VDD VDD net8 sky130_fd_sc_hd__clkdlybuf4s50_1
Xinput9 rd_en VSS VSS VDD VDD net9 sky130_fd_sc_hd__clkdlybuf4s50_1
Xinput10 rst_n VSS VSS VDD VDD net10 sky130_fd_sc_hd__clkdlybuf4s50_1
Xinput11 wr_en VSS VSS VDD VDD net11 sky130_fd_sc_hd__clkdlybuf4s50_1
Xoutput12 net12 VSS VSS VDD VDD dout[0] sky130_fd_sc_hd__clkdlybuf4s50_1
Xoutput13 net13 VSS VSS VDD VDD dout[1] sky130_fd_sc_hd__clkdlybuf4s50_1
Xoutput14 net14 VSS VSS VDD VDD dout[2] sky130_fd_sc_hd__clkdlybuf4s50_1
Xoutput15 net15 VSS VSS VDD VDD dout[3] sky130_fd_sc_hd__clkdlybuf4s50_1
Xoutput16 net16 VSS VSS VDD VDD dout[4] sky130_fd_sc_hd__clkdlybuf4s50_1
Xoutput17 net17 VSS VSS VDD VDD dout[5] sky130_fd_sc_hd__clkdlybuf4s50_1
Xoutput18 net18 VSS VSS VDD VDD dout[6] sky130_fd_sc_hd__clkdlybuf4s50_1
Xoutput19 net19 VSS VSS VDD VDD dout[7] sky130_fd_sc_hd__clkdlybuf4s50_1
Xoutput20 net20 VSS VSS VDD VDD empty sky130_fd_sc_hd__clkdlybuf4s50_1
Xoutput21 net21 VSS VSS VDD VDD full sky130_fd_sc_hd__clkdlybuf4s50_1
Xclkbuf_0_wr_clk wr_clk VSS VSS VDD VDD clknet_0_wr_clk sky130_fd_sc_hd__clkbuf_8
Xplace23 net10 VSS VSS VDD VDD net23 sky130_fd_sc_hd__buf_4
Xclkbuf_2_0__f_wr_clk clknet_0_wr_clk VSS VSS VDD VDD clknet_2_0__leaf_wr_clk
+ sky130_fd_sc_hd__clkbuf_8
Xclkbuf_2_1__f_wr_clk clknet_0_wr_clk VSS VSS VDD VDD clknet_2_1__leaf_wr_clk
+ sky130_fd_sc_hd__clkbuf_8
Xclkbuf_2_2__f_wr_clk clknet_0_wr_clk VSS VSS VDD VDD clknet_2_2__leaf_wr_clk
+ sky130_fd_sc_hd__clkbuf_8
Xclkbuf_2_3__f_wr_clk clknet_0_wr_clk VSS VSS VDD VDD clknet_2_3__leaf_wr_clk
+ sky130_fd_sc_hd__clkbuf_8
Xclkload0 clknet_2_0__leaf_wr_clk VSS VSS VDD VDD _unconnected_0
+ sky130_fd_sc_hd__clkinv_4
Xclkload1 clknet_2_1__leaf_wr_clk VSS VSS VDD VDD _unconnected_1
+ sky130_fd_sc_hd__bufinv_16
Xclkload2 clknet_2_3__leaf_wr_clk VSS VSS VDD VDD _unconnected_2
+ sky130_fd_sc_hd__clkinv_1
Xclkbuf_0_rd_clk rd_clk VSS VSS VDD VDD clknet_0_rd_clk sky130_fd_sc_hd__clkbuf_8
Xclkbuf_1_0__f_rd_clk clknet_0_rd_clk VSS VSS VDD VDD clknet_1_0__leaf_rd_clk
+ sky130_fd_sc_hd__clkbuf_8
Xclkbuf_1_1__f_rd_clk clknet_0_rd_clk VSS VSS VDD VDD clknet_1_1__leaf_rd_clk
+ sky130_fd_sc_hd__clkbuf_8
Xclkload3 clknet_1_1__leaf_rd_clk VSS VSS VDD VDD _unconnected_3
+ sky130_fd_sc_hd__bufinv_16
.ENDS async_fifo
